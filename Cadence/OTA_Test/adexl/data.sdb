ADE simulation setup
Run mode: Single Run, Sweeps and Corners
Tests:
  DC (off): OTA/OTA_Test/schematic, simulator spectre
  AC (off): OTA/OTA_Test/schematic, simulator spectre
  Trans (off): OTA/OTA_Test/schematic, simulator spectre
  Noise (off): OTA/OTA_Test/schematic, simulator spectre
  PSRR: OTA/OTA_Test/schematic, simulator spectre
  Offset (off): OTA/OTA_Test/schematic, simulator spectre
Global variables:
  dc_off = 0
  CL = 50f
  AmpTr = 100m
  finTr = 1M
  iBias = 2.2m
  Vcm = 1.95
  mul_bias = 8
  mul_n = 18
  mul_p = 3
  mul_in = 5
  mul_load = 1
  W5 = 28u
  W8 = 33u
  Rb = 2K
  V_bias = 200m 300m 600m
Corners:
  iBias (off): iBias=1.4m:300u:2.6m
  mul (off): iBias=800u:200u:2m; mul_n=1:1:30; mul_p=1:1:30
  mul2 (off): iBias=2.4m; mul_n=1:1:3; mul_p=1 2; mul_in=1 2
  AmpTr (off): AmpTr=30m:10m:100m
  fin (off): finTr=1k 100k 1M 7M 10M 20M 50M 70M
  Cout (off): CL=500f 1p 2p 3p 4p 5p
  Rout (off): RL=10K:10K:100K
  Vcm (off): Vcm=1 1.5 2 2.5 3
  MULP (off): iBias=400u 2.4m; mul_n=6:1:14
  casc (off): iBias=200u 1m; vcn=-2.5:0.25:2.5; vcp=-2.5:0.25:2.5
  W8 (off): iBias=1m 2.2m; W8=27u:1u:32u; W5=22u:0.5u:27u
  C0: Rb=1.5K:0.3K:3K
Specs:
  DC / M1 Region: range 1.9 to 2.1
  DC / M2 Region: range 1.9 to 2.1
  DC / M3 Region: range 1.9 to 2.1
  DC / M4 Region: range 1.9 to 2.1
  DC / M5 Region: range 1.9 to 2.1
  DC / M6 Region: range 1.9 to 2.1
  DC / M7 Region: range 1.9 to 2.1
  DC / M8 Region: range 1.9 to 2.1
  DC / MnB1 Region: range 1.9 to 2.1
  DC / MnB2 Region: range 1.9 to 2.1
  AC / PM: < 90
  DC / M16 Region: range 1.9 to 2.1
  DC / M15 Region: range 1.9 to 2.1
  DC / M11 Region: range 1.9 to 2.1
  DC / M10 Region: range 1.9 to 2.1
  DC / M9 Region: range 1.9 to 2.1
  DC / MpB1 Region: range 1.9 to 2.1
  DC / MpB2 Region: range 1.9 to 2.1
  DC / MnT1 Region: range 1.9 to 2.1
  DC / MnT2 Region: range 1.9 to 2.1
  Trans / HD2: < -30
  Trans / HD3: < -30
Single Run, Sweeps and Corners options: submitpointsenabled=0
