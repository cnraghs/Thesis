ADE simulation setup
Run mode: Single Run, Sweeps and Corners
Tests:
  DC: OTA/OTA_OPAMP_Test/schematic, simulator spectre
  AC: OTA/OTA_OPAMP_Test/schematic, simulator spectre
  Trans: OTA/OTA_OPAMP_Test/schematic, simulator spectre
  Noise: OTA/OTA_OPAMP_Test/schematic, simulator spectre
  PSRR: OTA/OTA_OPAMP_Test/schematic, simulator spectre
Global variables:
  AmpTr = 100m
  CL_OTA = 5f
  dc_off = 0
  finTr = 1M
  iBias = 1.5m
  idc = 50u
  mul_bias = 8
  mul_in = 5
  mul_load = 1
  mul_n = 18
  mul_p = 3
  RL = 50
  Vcm = 1.95
  W5 = 27u
  W8 = 33u
  mul_in_oa = 2
  Cc = 500f
  R = 1
  Rb = 2K
  V_bias = 425m
Corners:
  iBias (off): iBias=1.4m:200u:3m
  RL_W5 (off): iBias=1m 2.6m; W5=27u:1u:31u; RL=40 50
  Rb (off): Rb=1.5K:0.3K:3K
  Vbias (off): V_bias=150m:50m:700m
  RL: RL=35:5:70
Specs:
  Trans / HD2: < -30
  Trans / HD3: < -30
  AC / DC_Gain_Abs: > 5
  PSRR / PSRR_P: < 20u
  PSRR / PSRR_N: < 20u
  Noise / In_Ref_Noise: < 3n
  AC / BW_3dB: > 10M
  AC / PM: range 30 to 90
  AC / Zin@1MHz: > 550K
  AC / Zout@1MHz: > 55K
