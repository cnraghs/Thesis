ADE simulation setup
Run mode: Single Run, Sweeps and Corners
Tests:
  DC: OTA/OTA_OPAMP_BJT_Test/schematic, simulator spectre
  AC (off): OTA/OTA_OPAMP_BJT_Test/schematic, simulator spectre
  Trans (off): OTA/OTA_OPAMP_BJT_Test/schematic, simulator spectre
  Noise (off): OTA/OTA_OPAMP_BJT_Test/schematic, simulator spectre
  PSRR (off): OTA/OTA_OPAMP_BJT_Test/schematic, simulator spectre
Global variables:
  CL = 50f
  dc_off = -100u
  iBias = 600u 2.4m
  mul_bias = 7
  mul_in = 2
  mul_load = 1
  mul_n = 12
  mul_p = 2
  ampTr = 50m
  finTr = 1M
  RL = 12
  Vcm = 2
  gain = 300
  gbw = 20M
  ibias = 0
  rin = 10M
  rout = 10
  sr = 1G
  R1 = 100
  R2 = 100
  Cc = 20n
  RE = 12
Corners:
  iBias (off): iBias=600u:200u:2.4m
  CL (off): iBias=800u:200u:2.4m; CL=5f 20f 50f 75f 100f 200f
  GBW: gbw=10M:5M:40M
  finTr (off): finTr=10K 100K 500K 1M 2M 3M 5M 7M 10M 20M 50M 100M
  Gain1 (off): gain=20:5:45
  Gain2 (off): gain=50:10:90
  Gain3 (off): gain=100:50:500
Specs:
  AC / PM: < 90
