ADE simulation setup
Run mode: Single Run, Sweeps and Corners
Tests:
  DC (off): OTA/OPAMP_test/schematic, simulator spectre
  AC (off): OTA/OPAMP_test/schematic, simulator spectre
  Trans (off): OTA/OPAMP_test/schematic, simulator spectre
  ICMR (off): OTA/OPAMP_test/schematic, simulator spectre
  PSRR: OTA/OPAMP_test/schematic, simulator spectre
Global variables:
  Cc = 50f
  dc_off = 0
  idc = 50u
  RL = 50
  vcm = 0
  ampTr = 1.5
  mul_in_oa = 2
  Vcm = 0
  R = 2
Corners:
  Amp (off): ampTr=1:0.1:1.3
Specs:
  DC / M1_Region: range 1.9 to 2.1
  DC / M2_Region: range 1.9 to 2.1
  DC / M3_Region: range 1.9 to 2.1
  DC / M4_Region: range 1.9 to 2.1
  DC / M5_Region: range 1.9 to 2.1
  DC / M6_Region: range 1.9 to 2.1
  DC / M7_Region: range 1.9 to 2.1
  DC / nil: range 1.9 to 2.1
  DC / M9_Region: range 1.9 to 2.1
  DC / M10_Region: range 1.9 to 2.1
  DC / M8_Region: range 1.9 to 2.1
